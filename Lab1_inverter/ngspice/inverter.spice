.lib /home/mamatha/.volare/volare/sky130/versions/c6d73a35f524070e85faff4a6a9eef49553ebc2b/sky130A/libs.tech/ngspice/sky130.lib.spice tt

VDD vdd 0 1.8
VIN vin 0 PWL(0 0 900n 1.8)

XM1 vout vin 0 0 sky130_fd_pr__nfet_01v8 W=1 L=0.15
XM2 vout vin vdd vdd sky130_fd_pr__pfet_01v8 W=1 L=0.15

.control
tran 1n 1u
plot v(vin) v(vout)
.endc
.end
